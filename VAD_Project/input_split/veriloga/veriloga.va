// VerilogA for ECE1388_Final_Project, input_split, veriloga

`include "constants.vams"
`include "disciplines.vams"

module input_split(in, pos_o, neg_o);

	electrical in, pos_o, neg_o;
	input in;
	output pos_o, neg_o;

	parameter bias_voltage = 0.5;

	analog begin
		V(pos_o) <+ (bias_voltage +  (V(in)/2));
		V(neg_o) <+ (bias_voltage -  (V(in)/2));

	end

endmodule
