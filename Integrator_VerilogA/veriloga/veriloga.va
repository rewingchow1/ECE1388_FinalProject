// VerilogA for ECE1388_Final_Project, Integrator_VerilogA, veriloga

`include "constants.vams"
`include "disciplines.vams"

module integrator(in,out,switch);
input in;
input switch;
output out;
electrical in,switch,out;

parameter real cap = 10n from (0:inf);
parameter real vdd = 1;
parameter real vss = -1;
real x;

analog begin

	x = 1/cap*idt(V(in),0);
	if (x>=vdd) x = vdd;
	if (x<=vss) x = vss;
	if (V(switch) == vdd) x = 0;

	V(out)<+ x;

end

endmodule
